* Sirokko 24-to-5 diagnostic ONLY, no hardware power or CAD writes
* PCB source SHA256 9e10942d0e3e27358864b34ea380bc3fc3f7fcc24002788059a10cb5a8bf0444
* Values and named-node connectivity read from canonical PCB by native KiCad.
* TI Q1 model used as functional proxy for LM5013, NOT exact part qualification.
* Generic diode, nominal ideal L/C, fixed diagnostic load 5ohm; NOT DevKit load model.
* Ideal forced supply at P24_PROTECTED: upstream LM74800 and input storage omitted.
.include LM5013-Q1_TRANS_unencrypted_TI-E2E.LIB
VINPUT SUPPLY 0 PWL(0 0 1u 0 2u 24 5m 24 5.001m 12 5.2m 12 5.201m 24 10m 24)
V_BUCK SUPPLY VIN 0
R104 VIN EN 100k
R105 EN 0 10k
R103 RON 0 31.6k
C104 BST SW 2.2n
D101 0 SW D_GENERIC_SCHOTTKY
L101 SW VOUT 33u
C105 VOUT 0 47u ic=0
C106 VOUT 0 47u ic=0
R_DIAGNOSTIC_LOAD VOUT 0 5
R101 VOUT FB 31.6k
R102 FB 0 10k
R106 SW RAMP 82k
C107 RAMP VOUT 4.7n
C108 RAMP FB 820p
R107 VOUT PGOOD 10k
XU101 BST EN FB 0 0 PGOOD RON SW VIN LM5013-Q1_TRANS
.model D_GENERIC_SCHOTTKY D(Is=10u Rs=20m N=1.05 Cjo=300p Bv=100 Ibv=100u Tt=20n)
.temp 27
.options method=gear reltol=0.005 abstol=1n vntol=10u gmin=1e-10
.tran 100n 10m 0 100n
.control
set wr_singlescale
set wr_vecnames
run
wrdata sirokko_24to5_diagnostic.csv v(vin) v(vout) v(fb) v(en) i(L101) i(V_BUCK)
print v(vout)[length(v(vout))-1]
quit
.endc
.end
